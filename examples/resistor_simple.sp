* Simple Resistor Divider
* 5V -- R1 (1k) -- Vout -- R2 (2k) -- GND
* Expected Vout = 3.33V

VIN 1 0 DC 5.0
R1 1 2 1000
R2 2 0 2000

.end
