* Resistor Divider Circuit
* VIN (5V) -- R1 (1k) -- VOUT -- R2 (2k) -- GND

VIN in 0 DC 5.0
R1 in out 1000
R2 out 0 2000

.end
